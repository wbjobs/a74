VCV Test - Voltage Controlled Voltage Source
* VCV with gain 2 (voltage amplifier)
V1 1 0 DC 0 AC 1 0
R1 1 0 10000
E1 3 0 1 0 2
R2 3 0 1000
.ac single 1000
